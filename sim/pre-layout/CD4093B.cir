CD4093B
********************************************************************
****** kompletny uklad - 4 bramki wraz z buforami wyjsciowymi ******
********************************************************************
.lib tsmc180_t77a_spice.lib

.subckt SCHMITT_TRIGGER in out vdd vss
M1 1 in vss vss NFET l=.2u w=2u
M2 vdd in 1 vdd PFET l=.2u w=4u
M3 1 out vss vss NFET l=.2u w=.4u
M4 vdd out 1 vdd PFET l=.2u w=.8u
M5 out 1 vss vss NFET l=.2u w=.4u
M6 vdd 1 out vdd PFET l=.2u w=.8u
.ends

.subckt NAND A B out vdd vss
M1 vdd A out vdd PFET l=.2u w=.8u
M3 out A 1 0 NFET l=.2u w=.4u
M2 vdd B out vdd PFET l=.2u w=.8u
M4 1 B 0 0 NFET l=.2u w=.4u
.ends

.subckt OUTPUT_BUFFER in out vdd vss
M1 vdd in 1 vdd PFET l=.2u w=.8u
M2 1 in vss vss NFET l=.2u w=.4u
M3 vdd 1 2 vdd PFET l=.2u w=8.4u
M4 2 1 vss vss NFET l=.2u w=4.2u
M5 vdd 2 3 vdd PFET l=.2u w=89u
M6 3 2 vss vss NFET l=.2u w=44.5u
M7 vdd 3 out vdd PFET l=.2u w=938.7u
M8 out 3 vss vss NFET l=.2u w=469.4u
.ends

.subckt NAND_HYSTERESIS A B out vdd vss
X1 A nand_A vdd vss SCHMITT_TRIGGER
X2 B nand_B vdd vss SCHMITT_TRIGGER
X3 nand_A nand_B nand_out vdd vss NAND
X4 nand_out out vdd vss OUTPUT_BUFFER
.ends

.subckt CD4093B A B C D E F G H J K L M vdd vss
X1 A B J vdd vss NAND_HYSTERESIS
X2 C D K vdd vss NAND_HYSTERESIS
X3 E F L vdd vss NAND_HYSTERESIS
X4 G H M vdd vss NAND_HYSTERESIS
.ends

XCD4093B A B A B A B A B J K L M vdd 0 CD4093B
Cload_J J 0 25p
Cload_K K 0 25p
Cload_L L 0 25p
Cload_M M 0 25p

.param VDD=1.8V
.param Bin=1.8V

Vdd vdd 0 {VDD}
Vb B 0 {Bin}

.param freq=30MEG
.param Tperiod=1/{freq}
.param Ton=0.5*{Tperiod}

*VaCLOCK A 0 PULSE(0 1.8 0 1n 1n {Ton} {Tperiod}) ; przebieg prostokatny
; do badania maksymalnej czestotliwosci ukladu
VaSIN A 0 SINE(0.9V 0.9V {freq} 0 0 -90) ; przebieg sinusoidalny
; do zaobserwowania oraz wykreslenia histerezy

.tran 0 200n 0 100p
.op ; sprawdzenie podstawowej poprawnosci dzialania ukladu

.end
